* -----------------------------------------------------------------------
* own_cells -- the user's OWN standard-cell library, vendored.
*
* PROVENANCE (this repo's rule: copies with commit provenance, never edits):
*   source   regenerated from stdcells/flow/cells.py by importing LIBRARY and
*            calling Cell.spice() -- NOT copied from stdcells/out/own.spice,
*            which is a stale build artifact there (it predates BUF_X1 and so
*            carries only 8 of the 9 cells)
*   commit   stdcells @ b66020c80aa5766728024a3b9795c22a112775f6 (2026-07-21,
*            "BUF_X1: the hold-fix cell - 9th cell, all signoff clean"),
*            the last commit to touch flow/cells.py; file clean at vendoring
*   library  v2 sizing: L=0.15um, WN=0.65um, WP=1.0um, single-finger, one
*            netlist entry per PHYSICAL finger so the netlist is
*            topologically what the layout draws (LVS needs no overrides)
*
* These are the cells that were drawn, DRC/LVS-signed-off and characterized in
* stdcells, and that hardened CORDIC-1 with zero foundry cells in the netlist.
*
* TWO PROPERTIES OF THIS LIBRARY SHAPED THE SAR SEQUENCER, and neither is a
* modelling convenience:
*   - DFF_X1 has NO set and NO reset (dfxtp_1 topology, D/CLK -> Q), so every
*     reset in spice/sar_logic.sp is SYNCHRONOUS and built from gates.
*   - NAND3/NOR3 were deliberately dropped from the library, so every function
*     is composed from two-input gates.
*
* Do not edit this file. Regenerate it from stdcells at the commit above.
* -----------------------------------------------------------------------

* INV_X1: 2T, 3 sites, 3.7536 um2, function (!A)
.subckt INV_X1 A Y vdd vss
xm0 Y A vdd vdd sky130_fd_pr__pfet_01v8 w=1.0 l=0.15
xm1 Y A vss vss sky130_fd_pr__nfet_01v8 w=0.65 l=0.15
.ends

* INV_X2: 4T, 3 sites, 3.7536 um2, function (!A)
.subckt INV_X2 A Y vdd vss
xm0 Y A vdd vdd sky130_fd_pr__pfet_01v8 w=1.0 l=0.15
xm1 Y A vss vss sky130_fd_pr__nfet_01v8 w=0.65 l=0.15
xm2 Y A vdd vdd sky130_fd_pr__pfet_01v8 w=1.0 l=0.15
xm3 Y A vss vss sky130_fd_pr__nfet_01v8 w=0.65 l=0.15
.ends

* INV_X4: 8T, 5 sites, 6.256 um2, function (!A)
.subckt INV_X4 A Y vdd vss
xm0 Y A vdd vdd sky130_fd_pr__pfet_01v8 w=1.0 l=0.15
xm1 Y A vss vss sky130_fd_pr__nfet_01v8 w=0.65 l=0.15
xm2 Y A vdd vdd sky130_fd_pr__pfet_01v8 w=1.0 l=0.15
xm3 Y A vss vss sky130_fd_pr__nfet_01v8 w=0.65 l=0.15
xm4 Y A vdd vdd sky130_fd_pr__pfet_01v8 w=1.0 l=0.15
xm5 Y A vss vss sky130_fd_pr__nfet_01v8 w=0.65 l=0.15
xm6 Y A vdd vdd sky130_fd_pr__pfet_01v8 w=1.0 l=0.15
xm7 Y A vss vss sky130_fd_pr__nfet_01v8 w=0.65 l=0.15
.ends

* BUF_X1: 4T, 3 sites, 3.7536 um2, function A
.subckt BUF_X1 A Y vdd vss
xm0 yb A vdd vdd sky130_fd_pr__pfet_01v8 w=1.0 l=0.15
xm1 yb A vss vss sky130_fd_pr__nfet_01v8 w=0.65 l=0.15
xm2 Y yb vdd vdd sky130_fd_pr__pfet_01v8 w=1.0 l=0.15
xm3 Y yb vss vss sky130_fd_pr__nfet_01v8 w=0.65 l=0.15
.ends

* BUF_X2: 6T, 4 sites, 5.0048 um2, function A
.subckt BUF_X2 A Y vdd vss
xm0 yb A vdd vdd sky130_fd_pr__pfet_01v8 w=1.0 l=0.15
xm1 yb A vss vss sky130_fd_pr__nfet_01v8 w=0.65 l=0.15
xm2 Y yb vdd vdd sky130_fd_pr__pfet_01v8 w=1.0 l=0.15
xm3 Y yb vss vss sky130_fd_pr__nfet_01v8 w=0.65 l=0.15
xm4 Y yb vdd vdd sky130_fd_pr__pfet_01v8 w=1.0 l=0.15
xm5 Y yb vss vss sky130_fd_pr__nfet_01v8 w=0.65 l=0.15
.ends

* BUF_X4: 10T, 6 sites, 7.5072 um2, function A
.subckt BUF_X4 A Y vdd vss
xm0 yb A vdd vdd sky130_fd_pr__pfet_01v8 w=1.0 l=0.15
xm1 yb A vss vss sky130_fd_pr__nfet_01v8 w=0.65 l=0.15
xm2 Y yb vdd vdd sky130_fd_pr__pfet_01v8 w=1.0 l=0.15
xm3 Y yb vss vss sky130_fd_pr__nfet_01v8 w=0.65 l=0.15
xm4 Y yb vdd vdd sky130_fd_pr__pfet_01v8 w=1.0 l=0.15
xm5 Y yb vss vss sky130_fd_pr__nfet_01v8 w=0.65 l=0.15
xm6 Y yb vdd vdd sky130_fd_pr__pfet_01v8 w=1.0 l=0.15
xm7 Y yb vss vss sky130_fd_pr__nfet_01v8 w=0.65 l=0.15
xm8 Y yb vdd vdd sky130_fd_pr__pfet_01v8 w=1.0 l=0.15
xm9 Y yb vss vss sky130_fd_pr__nfet_01v8 w=0.65 l=0.15
.ends

* NAND2_X1: 4T, 3 sites, 3.7536 um2, function (!(A&B))
.subckt NAND2_X1 A B Y vdd vss
xm0 Y A vdd vdd sky130_fd_pr__pfet_01v8 w=1.0 l=0.15
xm1 Y B vdd vdd sky130_fd_pr__pfet_01v8 w=1.0 l=0.15
xm2 Y A m0 vss sky130_fd_pr__nfet_01v8 w=0.65 l=0.15
xm3 m0 B vss vss sky130_fd_pr__nfet_01v8 w=0.65 l=0.15
.ends

* NOR2_X1: 4T, 3 sites, 3.7536 um2, function (!(A|B))
.subckt NOR2_X1 A B Y vdd vss
xm0 m0 A vdd vdd sky130_fd_pr__pfet_01v8 w=1.0 l=0.15
xm1 Y B m0 vdd sky130_fd_pr__pfet_01v8 w=1.0 l=0.15
xm2 Y A vss vss sky130_fd_pr__nfet_01v8 w=0.65 l=0.15
xm3 Y B vss vss sky130_fd_pr__nfet_01v8 w=0.65 l=0.15
.ends

* DFF_X1: 24T, 13 sites, 16.2656 um2, clocked on CLK
.subckt DFF_X1 D CLK Q vdd vss
xm0 cn CLK vss vss sky130_fd_pr__nfet_01v8 w=0.42 l=0.15
xm1 cn CLK vdd vdd sky130_fd_pr__pfet_01v8 w=0.64 l=0.15
xm2 vss cn cp vss sky130_fd_pr__nfet_01v8 w=0.42 l=0.15
xm3 vdd cn cp vdd sky130_fd_pr__pfet_01v8 w=0.64 l=0.15
xm4 vdd D db vdd sky130_fd_pr__pfet_01v8 w=0.42 l=0.15
xm5 vss D db vss sky130_fd_pr__nfet_01v8 w=0.42 l=0.15
xm6 db cn m1 vss sky130_fd_pr__special_nfet_01v8 w=0.36 l=0.15
xm7 db cp m1 vdd sky130_fd_pr__pfet_01v8 w=0.42 l=0.15
xm8 vdd m1 m2 vdd sky130_fd_pr__pfet_01v8 w=0.75 l=0.15
xm9 vss m1 m2 vss sky130_fd_pr__nfet_01v8 w=0.64 l=0.15
xm10 mfn m2 vss vss sky130_fd_pr__nfet_01v8 w=0.42 l=0.15
xm11 m1 cp mfn vss sky130_fd_pr__special_nfet_01v8 w=0.36 l=0.15
xm12 mfp m2 vdd vdd sky130_fd_pr__pfet_01v8 w=0.42 l=0.15
xm13 m1 cn mfp vdd sky130_fd_pr__pfet_01v8 w=0.42 l=0.15
xm14 m2 cn s1 vdd sky130_fd_pr__pfet_01v8 w=0.42 l=0.15
xm15 m2 cp s1 vss sky130_fd_pr__special_nfet_01v8 w=0.36 l=0.15
xm16 s2 s1 vss vss sky130_fd_pr__nfet_01v8 w=0.65 l=0.15
xm17 s2 s1 vdd vdd sky130_fd_pr__pfet_01v8 w=1.0 l=0.15
xm18 sfn s2 vss vss sky130_fd_pr__nfet_01v8 w=0.42 l=0.15
xm19 s1 cn sfn vss sky130_fd_pr__special_nfet_01v8 w=0.36 l=0.15
xm20 s1 cp sfp vdd sky130_fd_pr__pfet_01v8 w=0.42 l=0.15
xm21 sfp s2 vdd vdd sky130_fd_pr__pfet_01v8 w=0.42 l=0.15
xm22 vdd s2 Q vdd sky130_fd_pr__pfet_01v8 w=1.0 l=0.15
xm23 vss s2 Q vss sky130_fd_pr__nfet_01v8 w=0.65 l=0.15
.ends
